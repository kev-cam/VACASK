* Two subcircuit geometries select bins with deliberately different thresholds.
.subckt nbin d g s b
.param l=1 w=1
M0 d g s b nbin_model l={l} w={w}
.model nbin_model.1 nmos level=49 lmin=1e-7 lmax=5e-7 wmin=1e-7 wmax=1e-3 vth0=0.35
.model nbin_model.2 nmos level=49 lmin=5e-7 lmax=1e-5 wmin=1e-7 wmax=1e-3 vth0=0.95
.ends
Xshort out_short gate 0 0 nbin l=3e-7 w=2e-6
Xlong out_long gate 0 0 nbin l=7e-7 w=2e-6
Rshort vdd out_short 2k
Rlong vdd out_long 2k
Vdd vdd 0 1.2
Vgate gate 0 1.2
.end
