* Bin selection when the M-instance does not pass bare `l`/`w`.
*
* `nind` mirrors the Sky130 20V FET shape: the subcircuit never declares `l`,
* the M-line takes its channel length from a local .param, so a bin guard
* written against subckt-scope `l` cannot resolve.
.subckt nind d g s b lsel=1
.param lgate={lsel}
M0 d g s b nind_model l={lgate} w=2e-6
.model nind_model.1 nmos level=49 lmin=1e-7 lmax=5e-7 wmin=1e-7 wmax=1e-3 vth0=0.35
.model nind_model.2 nmos level=49 lmin=5e-7 lmax=1e-5 wmin=1e-7 wmax=1e-3 vth0=0.95
.ends
* `nplain` mirrors the Sky130 ESD FETs: a single .model card carrying binning
* bounds but no `.<digits>` suffix. ngspice matches such a card by exact name
* and never bins it, so the out-of-range bounds below must not hide it.
.subckt nplain d g s b
M0 d g s b nplain_model l=3e-7 w=2e-6
.model nplain_model nmos level=49 lmin=1 lmax=2 wmin=1 wmax=2 vth0=0.35
.ends
Xshort out_short gate 0 0 nind lsel=3e-7
Xlong out_long gate 0 0 nind lsel=7e-7
Xplain out_plain gate 0 0 nplain
Rshort vdd out_short 2k
Rlong vdd out_long 2k
Rplain vdd out_plain 2k
Vdd vdd 0 1.2
Vgate gate 0 1.2
.end
