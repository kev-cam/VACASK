// A6 — Breakpoint prediction test
//
// A slow linear ramp with a known crossing that does not land on the
// solver's natural step grid.  Without forward-prediction, the solver
// would step right past the crossing.  With forward-prediction, the
// callback injects a breakpoint at the predicted crossing time, forcing
// the solver to land at (or very near) the analytical crossing.
//
// Also includes a D2A loopback: when the digital side detects the
// crossing, it drives a D2A output high.  The analog ramp drives
// through a buffer resistor so we can observe the D2A response.
//
// RAMP: linear 0 → 3.0V over 10 µs
//   vth_hi = 1.55V → t_cross = (1.55/3.0) * 10µs = 5166.667 ns
//   vth_lo = 0.5V (not expected to trigger posedge on this ramp)
//
// tstep=500n is configured, but VACASK also bounds the timestep to
// tstop/tran_minpts (tran_minpts defaults to 50), which is 10us/50 =
// 200 ns here — tighter than the configured 500 ns, so 200 ns is the
// actual natural step. Measured on a clean run: natural grid steps
// ...4775 -> 4975 -> 5175..., landing 8.3 ns past the 5166.667 ns
// crossing with no breakpoint. With forward-prediction, the callback
// at t=4975 sees slope dv/dt=0.3 V/us, v=1.4925V, needs 0.0575V to
// reach 1.55V, predicts crossing at 4975 + 191.667 = 5166.667 ns and
// injects a breakpoint there, shortening that step from 200 ns to
// 191.7 ns.

ground 0

load "resistor.osdi"
load "capacitor.osdi"

model vsrc vsource
model res  resistor
model cap  capacitor

// Slow ramp: 0 → 3.0V over 10 µs
v_ramp (RAMP 0) vsrc type="pwl" wave=[0, 0, 10e-6, 3.0]
r_ramp (RAMP 0) res r=1e12

// D2A loopback node — current source injected here by bridge
r_d2a (LOOPBACK 0) res r=1e12
