// A1 — Ramp crossing: analytical crossing times
//
// Three sources with closed-form vth_hi=1.2V crossing times:
//
//   RAMP_SLOW:  linear 0→1.8V over 10µs
//     t_cross = (1.2/1.8) * 10µs = 6666.667 ns
//
//   RAMP_FAST:  linear 0→1.8V over 1µs
//     t_cross = (1.2/1.8) * 1µs  = 666.667 ns
//
//   RC_CHARGE:  V(t) = 1.8*(1 - exp(-t/2µs))
//     t_cross = -2µs * ln(1 - 1.2/1.8) = 2197.225 ns
//

ground 0

load "resistor.osdi"
load "capacitor.osdi"

model vsrc vsource
model res  resistor
model cap  capacitor

// --- Slow ramp: 0 → 1.8V in 10µs (slope = 0.18 V/µs) ---
v_slow (RAMP_SLOW 0) vsrc type="pwl" wave=[0, 0, 10e-6, 1.8]
r_slow (RAMP_SLOW 0) res r=1e12

// --- Fast ramp: 0 → 1.8V in 1µs (slope = 1.8 V/µs) ---
v_fast (RAMP_FAST 0) vsrc type="pwl" wave=[0, 0, 1e-6, 1.8]
r_fast (RAMP_FAST 0) res r=1e12

// --- RC charge curve: step → R → C ---
// V_RC(t) = 1.8 * (1 - exp(-t / (R*C)))
// R = 20 kΩ, C = 100 pF  →  τ = 2 µs
v_step (RC_IN 0) vsrc type="pwl" wave=[0, 0, 0.1e-9, 1.8]
r_rc   (RC_IN RC_CHARGE) res r=20000
c_rc   (RC_CHARGE 0) cap c=100e-12

control
tran tstop=12e-6 tstep=50e-9
endc
