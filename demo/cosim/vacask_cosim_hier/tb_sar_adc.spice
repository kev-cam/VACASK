** sch_path: /home/alberto/Scaricati/ngspice_verilog_cosim/vacask_cosim_hier/final_folder/tb_sar_adc.sch
**.subckt tb_sar_adc
VAMM SUM 0 0
R2 D5 SUM 2
R3 D4 SUM 4
R4 D3 SUM 8
R5 D2 SUM 16
R6 D1 SUM 32
R7 D0 SUM 64
V3 VCC 0 dc=VCC
V2 INPUT 0 type="pulse" val0=0 val1=3 delay=0 rise=200u fall=200u width=1u period=402u
V1 START 0 type="pulse" val0=0 val1=VCC delay=0.2u rise=10n fall=10n width=1.3u period=10u
V4 CLK 0 type="pulse" val0=0 val1='VCC' delay=500n rise=10n fall=10n width=490n period=1u
x1 INPUT VCC START VALID D[5] D[4] D[3] D[2] D[1] D[0] CLK sar_adc
x2 VALID_A VALID dac_bridge
**** begin user architecture code

ground 0

load "resistor.osdi"
load "capacitor.osdi"

parameters VCC=3.3

control
  tran tran1 tstop=250u tstep=10n
endc

**** end user architecture code
**.ends

* expanding   symbol:  /home/alberto/Scaricati/ngspice_verilog_cosim/vacask_cosim_hier/final_folder/sar_adc.sym # of pins=6
** sym_path: /home/alberto/Scaricati/ngspice_verilog_cosim/vacask_cosim_hier/final_folder/sar_adc.sym
** sch_path: /home/alberto/Scaricati/ngspice_verilog_cosim/vacask_cosim_hier/final_folder/sar_adc.sch
.subckt sar_adc INPUT VREF START VALID D[5] D[4] D[3] D[2] D[1] D[0] CLK
*.ipin INPUT
*.ipin VREF
*.ipin START
*.opin VALID
*.ipin CLK
*.opin D[5],D[4],D[3],D[2],D[1],D[0]
CLAST TEST_V 0 31.25f
R1 IIN TEST_V 1k
x1 INPUT IIN SAMPLE VREF tgate
x2 TEST_V VREF D[0] ccap C = 1p/32
x3 TEST_V VREF D[1] ccap C = 1p/16
x4 TEST_V VREF D[2] ccap C = 1p/8
x5 TEST_V VREF D[3] ccap C = 1p/4
x6 TEST_V VREF D[4] ccap C = 1p/2
x7 TEST_V VREF D[5] ccap C = 1p
x8 CLK COMP VALID D[5] D[4] D[3] D[2] D[1] D[0] SAMPLE START sar_adc_vlog
* noconn COMP
* noconn %vd(TEST_V VREF)
acomp COMP %vd(TEST_V VREF) acomp
DAC COMP_A COMP dac_bridge
.ends

* expanding   symbol:  /home/alberto/Scaricati/ngspice_verilog_cosim/vacask_cosim_hier/final_folder/dac_bridge.sym # of pins=2
** sym_path: /home/alberto/Scaricati/ngspice_verilog_cosim/vacask_cosim_hier/final_folder/dac_bridge.sym
** sch_path: /home/alberto/Scaricati/ngspice_verilog_cosim/vacask_cosim_hier/final_folder/dac_bridge.sch
.subckt dac_bridge aout din
*.opin aout
*.ipin din
**** begin user architecture code

model dac_model dac vth=0 vsoft=10m vout_low=0 vout_high=3.3
DAC (din aout) dac_model

**** end user architecture code
.ends

* expanding   symbol:  /home/alberto/Scaricati/ngspice_verilog_cosim/vacask_cosim_hier/final_folder/tgate.sym # of pins=4
** sym_path: /home/alberto/Scaricati/ngspice_verilog_cosim/vacask_cosim_hier/final_folder/tgate.sym
** sch_path: /home/alberto/Scaricati/ngspice_verilog_cosim/vacask_cosim_hier/final_folder/tgate.sch
.subckt tgate A B CTL VDD
*.ipin CTL
*.iopin B
*.iopin A
*.ipin VDD
* noconn VDD
XM1 A CTL B 0 sg13_lv_nmos w=5u l=0.13u ng=1
.ends

* expanding   symbol:  /home/alberto/Scaricati/ngspice_verilog_cosim/vacask_cosim_hier/final_folder/ccap.sym # of pins=3
** sym_path: /home/alberto/Scaricati/ngspice_verilog_cosim/vacask_cosim_hier/final_folder/ccap.sym
** sch_path: /home/alberto/Scaricati/ngspice_verilog_cosim/vacask_cosim_hier/final_folder/ccap.sch
.subckt ccap IN VCC CTL  C=1p
*.ipin IN
*.ipin VCC
*.ipin CTL
CB IN TAIL 'C'
*  x1 -  ainv  IS MISSING !!!!
.ends

* expanding   symbol:  /home/alberto/Scaricati/ngspice_verilog_cosim/vacask_cosim_hier/final_folder/sar_adc_vlog.sym # of pins=6
** sym_path: /home/alberto/Scaricati/ngspice_verilog_cosim/vacask_cosim_hier/final_folder/sar_adc_vlog.sym
** sch_path: /home/alberto/Scaricati/ngspice_verilog_cosim/vacask_cosim_hier/final_folder/sar_adc_vlog.sch
.subckt sar_adc_vlog Clk Comp Done Result[5] Result[4] Result[3] Result[2] Result[1] Result[0] Sample Start
*.ipin Clk
*.opin Sample
*.ipin Comp
*.ipin Start
*.opin Done
*.opin Result[5],Result[4],Result[3],Result[2],Result[1],Result[0]
Rclk 0 Clk 1G
R3 0 Sample 1G
R2 0 Done 1G
R1 0 Result[5] 1G
Rclk1 0 Comp 1G
Rclk2 0 Start 1G
.ends

* expanding   symbol:  /home/alberto/Scaricati/ngspice_verilog_cosim/vacask_cosim_hier/final_folder/acomp.sym # of pins=2
** sym_path: /home/alberto/Scaricati/ngspice_verilog_cosim/vacask_cosim_hier/final_folder/acomp.sym
** sch_path: /home/alberto/Scaricati/ngspice_verilog_cosim/vacask_cosim_hier/final_folder/acomp.sch
.subckt acomp dout ain
*.ipin ain
*.opin dout
* noconn ain
* noconn dout
**** begin user architecture code

model comparator_model comparator vth=0 vsoft=10m vout_low=0 vout_high=3.3
ACOMP (ain dout) comparator_model

**** end user architecture code
.ends

.end
